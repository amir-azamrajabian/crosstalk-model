** Profile: "SCHEMATIC1-Ideal"  [ E:\Project\Pspice\Model\shoot-through-schematic1-ideal.sim ]

** Creating circuit file "shoot-through-schematic1-ideal.sim.cir"
** WARNING: THIS AUTOMATICALLY GENERATED FILE MAY BE OVERWRITTEN BY SUBSEQUENT SIMULATIONS

*Libraries:
* Local Libraries :
* From [PSPICE NETLIST] section of C:\Program Files\Orcad\PSpice\PSpice.ini file:
.lib "nom.lib"

*Analysis directives:
.TRAN  0 4u 0 100p
.PROBE V(*) I(*) W(*) D(*) NOISE(*)
.INC "../SCHEMATIC1.net"

.END
